** sch_path: /foss/designs/adex_neuron/ttihp26a-adex-neuron-ncs/xschem/neuron_noahp_tb.sch
**.subckt neuron_noahp_tb
Xneuron VDD I_in I_lk I_lk vmem REQ ACK I_ref GND neuron_noahp
Ilk VDD I_lk 4p
Iin VDD I_in dc 0 ac 0 pulse(0 Iin_amp 0 20n 20n 1 1)
VDD1 VDD net1 1.2
Iref VDD I_ref 10n
Vidd net1 GND 0
.save i(vidd)
XM27 I_lk I_lk GND GND sg13_hv_nmos w=4u l=4u ng=2 m=4
Xinv3 VDD REQ net2 GND inv
Xinv4 VDD net2 ACK GND inv
C2 I_lk GND 2p
XM1 I_ref I_ref GND GND sg13_hv_nmos w=4u l=4u ng=2 m=4
C1 I_ref GND 2p
xv2i VDD V_bias V_cm V_in GND GND V2I_shift_final
XM3 V_bias V_bias VDD VDD sg13_hv_pmos w=4u l=1u ng=1 m=4
C3 VDD V_bias 2p
Ilk1 V_bias GND 6n
Vcm V_cm GND 0.4
Vin V_in GND sine(0.4 50m 10)
Viinprob net3 GND 0
.save i(viinprob)
**** begin user architecture code

.param temp=27
.param Iin_amp=200p

.ic V(vmem)=0 V(xneuron.xref.vref)=0 V(REQ)=1.2 V(ACK)=1.2

.options gmin=1e-13
.options method=gear
.control

* ======================================================
*  Iin sweep - measure firing rate of V(REQ) vs Iin
* ======================================================
*  For each DC value of Iin a transient simulation is run.
*  Rising-edge crossings of V(REQ) through a threshold
*  are counted after a settling window and the firing
*  frequency is computed.  Results go to neuron_iin_sweep.raw
* ======================================================

* --- Sweep parameters (Amps) - edit as needed ---
let iin_start = 0
let iin_stop  = 4000e-12
let iin_step  = 200e-12

* --- Compute number of sweep points ---
let num_pts = (iin_stop - iin_start) / iin_step + 1

* --- Create a new plot to hold the accumulated results ---
setplot new
set resplot = $curplot
let iin_values   = unitvec(num_pts)
let firing_rates = unitvec(num_pts)
let sweep_idx = 0
set t_sim = 50m

* --- Main sweep loop ---
dowhile sweep_idx < num_pts

  * Compute cur_iin fresh each iteration to avoid float drift
  let cur_iin = iin_start + sweep_idx * iin_step

  echo
  echo ============================================
  echo   Sweep point: Iin = $&cur_iin A
  echo ============================================

  * Save cur_iin to a shell variable before tran changes the plot context
  set cur_iin_val = $&cur_iin

  * Set the Iin_amp parameter to the current sweep value.
  alterparam Iin_amp = $cur_iin_val
  reset

  save V(REQ)

  * Run transient analysis with adaptive time
  echo   t_sim = $t_sim
  tran 50n $t_sim

  * --- Measure firing frequency using meas tran ---
  * Skip 1st spike (different freq from resting), use 2nd-4th spikes
  let t_fall1 = 0
  let t_fall2 = 0
  let t_fall3 = 0
  let t_fall4 = 0
  meas tran t_fall1 WHEN v(REQ)=0.6 FALL=1
  meas tran t_fall2 WHEN v(REQ)=0.6 FALL=2
  meas tran t_fall3 WHEN v(REQ)=0.6 FALL=3
  meas tran t_fall4 WHEN v(REQ)=0.6 FALL=4

  * Use best available data for frequency
  * More than 1 spike: f = (N-1) / (t_last - t_first)
  * Exactly 1 spike:   f = 1 / t_first
  if t_fall4 > 0
    * 4 spikes: use span from 1st to 4th
    let f_rate = 3.0 / (t_fall4 - t_fall1)
  else
    if t_fall3 > 0
      * 3 spikes: use span from 1st to 3rd
      let f_rate = 2.0 / (t_fall3 - t_fall1)
    else
      if t_fall2 > 0
        * 2 spikes: use span from 1st to 2nd
        let f_rate = 1.0 / (t_fall2 - t_fall1)
      else
        if t_fall1 > 0
          * 1 spike: estimate from time to 1st spike
          let f_rate = 1.0 / t_fall1
        else
          * No spikes
          let f_rate = 0
        end
      end
    end
  end

  echo   freq = $&f_rate Hz
  echo   Spike times:
  echo     t_fall1 = $&t_fall1 s
  echo     t_fall2 = $&t_fall2 s
  echo     t_fall3 = $&t_fall3 s
  echo     t_fall4 = $&t_fall4 s

  * --- Update t_sim for next sweep point ---
  * Need ~5 spikes worth of time, clamp to [1ms, 50ms]
  if f_rate > 0
    let t_next = 5.0 / f_rate
    if t_next < 1e-3
      let t_next = 1e-3
    end
    if t_next > 50e-3
      let t_next = 50e-3
    end
    set t_sim = $&t_next
  end

  * --- Store this point's results in the result plot ---
  set save_freq = $&f_rate
  setplot $resplot
  let iin_values[sweep_idx]   = $cur_iin_val
  let firing_rates[sweep_idx] = $save_freq
  let sweep_idx = sweep_idx + 1

end

* --- Write the result vectors to a .raw file ---
setplot $resplot
write neuron_iin_sweep.raw iin_values firing_rates

echo
echo ============================================
echo   Iin sweep complete!
echo   Results saved to:  neuron_iin_sweep.raw
echo   Vectors:
echo     iin_values   (A)  - input current
echo     firing_rates (Hz) - neuron firing rate
echo ============================================

.endc

.lib cornerMOSlv.lib mos_tt
.lib cornerMOShv.lib mos_tt

**** end user architecture code
**.ends

* expanding   symbol:  neuron_noahp.sym # of pins=9
** sym_path: /foss/designs/adex_neuron/ttihp26a-adex-neuron-ncs/xschem/neuron_noahp.sym
** sch_path: /foss/designs/adex_neuron/ttihp26a-adex-neuron-ncs/xschem/neuron_noahp.sch
.subckt neuron_noahp VDD I_in V_th V_lk Vmem REQ ACK V_ref GND
*.ipin V_ref
*.iopin GND
*.iopin VDD
*.opin REQ
*.ipin ACK
*.ipin I_in
*.ipin V_th
*.ipin V_lk
*.opin Vmem
Xinv1 VDD Vfb net1 GND inv
Xinv2 VDD net1 REQ GND inv
Xdpi1 I_in VDD V_th Vmem V_lk GND DPI
Xfb VDD Vfb Vmem GND FB_system
Xref VDD ACK Vmem REQ V_ref GND REF_system
Cmem Vmem GND 1p
.ends

* expanding   symbol:  inv.sym # of pins=4
** sym_path: /foss/designs/adex_neuron/ttihp26a-adex-neuron-ncs/xschem/inv.sym
** sch_path: /foss/designs/adex_neuron/ttihp26a-adex-neuron-ncs/xschem/inv.sch
.subckt inv VDD in out GND
*.ipin in
*.iopin VDD
*.iopin GND
*.opin out
XM1 out in VDD VDD sg13_hv_pmos w=1u l=0.5u ng=1
XM2 out in GND GND sg13_hv_nmos w=1u l=0.5u ng=1
.ends

* expanding   symbol:  V2I_shift_final.sym # of pins=6
** sym_path: /foss/designs/adex_neuron/ttihp26a-adex-neuron-ncs/xschem/V2I_shift_final.sym
** sch_path: /foss/designs/adex_neuron/ttihp26a-adex-neuron-ncs/xschem/V2I_shift_final.sch
.subckt V2I_shift_final VDD Vbias inn_cm inp_cm out GND
*.ipin inn_cm
*.ipin inp_cm
*.opin out
*.ipin Vbias
*.iopin VDD
*.iopin GND
VIout net2 out 0
.save i(viout)
XM2 net3 inp_cm Vhead VDD sg13_hv_pmos w=4u l=1u ng=1 m=4
XM5 net1 net1 GND GND sg13_hv_nmos w=4u l=1u ng=1 m=4
Vbias1 net6 Vhead 0
.save i(vbias1)
Vbranch1 net5 net2 0
.save i(vbranch1)
Vbranch2 net3 net1 0
.save i(vbranch2)
Vbranch3 net2 net4 0
.save i(vbranch3)
XM13 net6 Vbias VDD VDD sg13_hv_pmos w=4u l=1u ng=1 m=4
XM1 net4 net1 GND GND sg13_hv_nmos w=4u l=1u ng=1 m=4
XM3 net5 inn_cm Vhead VDD sg13_hv_pmos w=4u l=1u ng=1 m=4
Vbias3 net7 out 0
.save i(vbias3)
XM4 net7 Vbias VDD VDD sg13_hv_pmos w=4u l=1u ng=1 m=3
.ends

* expanding   symbol:  DPI.sym # of pins=6
** sym_path: /foss/designs/adex_neuron/ttihp26a-adex-neuron-ncs/xschem/DPI.sym
** sch_path: /foss/designs/adex_neuron/ttihp26a-adex-neuron-ncs/xschem/DPI.sch
.subckt DPI I_in VDD V_th V_mem V_lk GND
*.opin V_mem
*.ipin V_lk
*.ipin V_th
*.ipin I_in
*.iopin VDD
*.iopin GND
XMdifl GND V_th I_in VDD sg13_hv_pmos w=4u l=2u ng=2 m=8
XMdifr V_mem V_mem I_in VDD sg13_hv_pmos w=4u l=2u ng=2 m=8
XMtau net1 V_lk GND GND sg13_hv_nmos w=4u l=4u ng=2 m=4
Vilk V_mem net1 0
.save i(vilk)
.ends

* expanding   symbol:  FB_system.sym # of pins=4
** sym_path: /foss/designs/adex_neuron/ttihp26a-adex-neuron-ncs/xschem/FB_system.sym
** sch_path: /foss/designs/adex_neuron/ttihp26a-adex-neuron-ncs/xschem/FB_system.sch
.subckt FB_system VDD out V_mem GND
*.opin out
*.iopin V_mem
*.iopin VDD
*.iopin GND
XMmirr Vmir Vmir VDD VDD sg13_hv_pmos w=4u l=2u ng=4
XMmirl4 V_mem Vmir net1 VDD sg13_hv_pmos w=1u l=2u ng=1
XMthr out V_mem Vmir VDD sg13_hv_pmos w=4u l=2u ng=4
XMmem1 out V_mem net2 GND sg13_hv_nmos w=1u l=2u ng=1 m=2
XMmirl3 net1 Vmir net3 VDD sg13_hv_pmos w=1u l=2u ng=1
XMmirl2 net3 Vmir net4 VDD sg13_hv_pmos w=1u l=2u ng=1
XMmirl1 net4 Vmir VDD VDD sg13_hv_pmos w=1u l=2u ng=1
XMmem2 net2 V_mem net5 GND sg13_hv_nmos w=1u l=2u ng=1 m=2
XMmem3 net5 V_mem net6 GND sg13_hv_nmos w=1u l=2u ng=1 m=2
XMmem4 net6 V_mem GND GND sg13_hv_nmos w=1u l=2u ng=1 m=2
.ends

* expanding   symbol:  REF_system.sym # of pins=6
** sym_path: /foss/designs/adex_neuron/ttihp26a-adex-neuron-ncs/xschem/REF_system.sym
** sch_path: /foss/designs/adex_neuron/ttihp26a-adex-neuron-ncs/xschem/REF_system.sch
.subckt REF_system VDD ACK V_mem REQ V_ref GND
*.iopin VDD
*.iopin GND
*.ipin V_ref
*.ipin REQ
*.ipin ACK
*.ipin V_mem
Cr Vref GND 0.5p
XM10 Vref REQ net2 VDD sg13_hv_pmos w=1u l=0.5u ng=1
XM11 Vref REQ net1 GND sg13_hv_nmos w=1u l=0.5u ng=1
XM12 net2 ACK VDD VDD sg13_hv_pmos w=1u l=0.5u ng=1
XM13 V_mem Vref GND GND sg13_hv_nmos w=1u l=0.5u ng=1
XM14 net1 V_ref GND GND sg13_hv_nmos w=4u l=4u ng=2 m=4
.ends

.GLOBAL GND
.GLOBAL VDD
.end
