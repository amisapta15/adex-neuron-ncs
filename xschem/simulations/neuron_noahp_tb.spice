** sch_path: /foss/designs/adex_neuron/chenxi_working/ttihp26a-adex-neuron-ncs/xschem/neuron_noahp_tb.sch
**.subckt neuron_noahp_tb
Xneuron VDD I_in I_lk I_lk vmem REQ ACK I_ref GND neuron_noahp
Ilk VDD I_lk 4p
Iin VDD I_in dc 0 ac 0 pulse(0 Iin_amp 0 20n 20n 1 1)
VDD1 VDD net1 1.2
Iref VDD I_ref 10n
Vidd net1 GND 0
.save i(vidd)
XM27 I_lk I_lk GND GND sg13_hv_nmos w=4u l=4u ng=2 m=4
Xinv3 VDD REQ net2 GND inv
Xinv4 VDD net2 ACK GND inv
C2 I_lk GND 2p
XM1 I_ref I_ref GND GND sg13_hv_nmos w=4u l=4u ng=2 m=4
C1 I_ref GND 2p
xv2i VDD V_bias V_cm V_in GND GND V2I_shift_final
XM3 V_bias V_bias VDD VDD sg13_hv_pmos w=4u l=1u ng=1 m=4
C3 VDD V_bias 2p
Ilk1 V_bias GND 6n
Vcm V_cm GND 0.4
Vin V_in GND sine(0.4 50m 10)
Viinprob net3 GND 0
.save i(viinprob)
**** begin user architecture code

.param temp=27
.param Iin_amp=4n

.ic V(vmem)=0 V(xneuron.xref.vref)=0 V(REQ)=1.2 V(ACK)=1.2

.options gmin=1e-13
.control

save V(I_lk) V(I_in) I(Viinprob)
save V(ACK) V(REQ) V(vmem) V(xneuron.xref.vref)
save V(xneuron.xfb.vmir) V(xneuron.vfb)
save V(xneuron.xfb.nwell) V(xneuron.xfb.psub)
save V(V_in) V(V_cm) V(xv2i.vhead)

tran 50n 20m
write neuron_noahp_tb.raw
.endc

.lib cornerMOSlv.lib mos_tt
.lib cornerMOShv.lib mos_tt
.lib cornerRES.lib res_typ

**** end user architecture code
**.ends

* expanding   symbol:  neuron_noahp.sym # of pins=9
** sym_path: /foss/designs/adex_neuron/chenxi_working/ttihp26a-adex-neuron-ncs/xschem/neuron_noahp.sym
** sch_path: /foss/designs/adex_neuron/chenxi_working/ttihp26a-adex-neuron-ncs/xschem/neuron_noahp.sch
.subckt neuron_noahp VDD I_in V_th V_lk Vmem REQ ACK V_ref GND
*.ipin V_ref
*.iopin GND
*.iopin VDD
*.opin REQ
*.ipin ACK
*.ipin I_in
*.ipin V_th
*.ipin V_lk
*.opin Vmem
Xinv1 VDD Vfb net1 GND inv
Xinv2 VDD net1 REQ GND inv
Xdpi1 I_in VDD V_th Vmem V_lk GND DPI
Xfb VDD Vfb Vmem GND nwell psub FB_system
Xref VDD ACK Vmem REQ V_ref GND REF_system
Cmem Vmem GND 1p
.ends

* expanding   symbol:  inv.sym # of pins=4
** sym_path: /foss/designs/adex_neuron/chenxi_working/ttihp26a-adex-neuron-ncs/xschem/inv.sym
** sch_path: /foss/designs/adex_neuron/chenxi_working/ttihp26a-adex-neuron-ncs/xschem/inv.sch
.subckt inv VDD in out GND
*.ipin in
*.iopin VDD
*.iopin GND
*.opin out
XM1 out in VDD VDD sg13_hv_pmos w=1u l=0.5u ng=1
XM2 out in GND GND sg13_hv_nmos w=1u l=0.5u ng=1
.ends

* expanding   symbol:  V2I_shift_final.sym # of pins=6
** sym_path: /foss/designs/adex_neuron/chenxi_working/ttihp26a-adex-neuron-ncs/xschem/V2I_shift_final.sym
** sch_path: /foss/designs/adex_neuron/chenxi_working/ttihp26a-adex-neuron-ncs/xschem/V2I_shift_final.sch
.subckt V2I_shift_final VDD Vbias inn_cm inp_cm out GND
*.ipin inn_cm
*.ipin inp_cm
*.opin out
*.ipin Vbias
*.iopin VDD
*.iopin GND
VIout net2 out 0
.save i(viout)
XM2 net3 inp_cm Vhead VDD sg13_hv_pmos w=4u l=1u ng=1 m=4
XM5 net1 net1 GND GND sg13_hv_nmos w=4u l=1u ng=1 m=4
Vbias1 net6 Vhead 0
.save i(vbias1)
Vbranch1 net5 net2 0
.save i(vbranch1)
Vbranch2 net3 net1 0
.save i(vbranch2)
Vbranch3 net2 net4 0
.save i(vbranch3)
XM13 net6 Vbias VDD VDD sg13_hv_pmos w=4u l=1u ng=1 m=4
XM1 net4 net1 GND GND sg13_hv_nmos w=4u l=1u ng=1 m=4
XM3 net5 inn_cm Vhead VDD sg13_hv_pmos w=4u l=1u ng=1 m=4
Vbias3 net7 out 0
.save i(vbias3)
XM4 net7 Vbias VDD VDD sg13_hv_pmos w=4u l=1u ng=1 m=3
.ends

* expanding   symbol:  DPI.sym # of pins=6
** sym_path: /foss/designs/adex_neuron/chenxi_working/ttihp26a-adex-neuron-ncs/xschem/DPI.sym
** sch_path: /foss/designs/adex_neuron/chenxi_working/ttihp26a-adex-neuron-ncs/xschem/DPI.sch
.subckt DPI I_in VDD V_th V_mem V_lk GND
*.opin V_mem
*.ipin V_lk
*.ipin V_th
*.ipin I_in
*.iopin VDD
*.iopin GND
XMdifl GND V_th I_in VDD sg13_hv_pmos w=2u l=2u ng=2 m=8
XMdifr V_mem V_mem I_in VDD sg13_hv_pmos w=2u l=2u ng=2 m=8
XMtau net1 V_lk GND GND sg13_hv_nmos w=4u l=4u ng=2 m=4
Vilk V_mem net1 0
.save i(vilk)
.ends

* expanding   symbol:  FB_system.sym # of pins=6
** sym_path: /foss/designs/adex_neuron/chenxi_working/ttihp26a-adex-neuron-ncs/xschem/FB_system.sym
** sch_path: /foss/designs/adex_neuron/chenxi_working/ttihp26a-adex-neuron-ncs/xschem/FB_system.sch
.subckt FB_system VDD out V_mem GND nwell psub
*.opin out
*.iopin V_mem
*.iopin VDD
*.iopin GND
*.iopin nwell
*.iopin psub
XMmirr Vmir Vmir VDD nwell sg13_hv_pmos w=4u l=2u ng=4
XMmirl4 V_mem Vmir net1 nwell sg13_hv_pmos w=1u l=2u ng=1
XMthr out V_mem Vmir nwell sg13_hv_pmos w=4u l=2u ng=4
XMmem1 out V_mem net2 psub sg13_hv_nmos w=1u l=2u ng=1 m=2
XMmirl3 net1 Vmir net3 nwell sg13_hv_pmos w=1u l=2u ng=1
XMmirl2 net3 Vmir net4 nwell sg13_hv_pmos w=1u l=2u ng=1
XMmirl1 net4 Vmir VDD nwell sg13_hv_pmos w=1u l=2u ng=1
XMmem2 net2 V_mem net5 psub sg13_hv_nmos w=1u l=2u ng=1 m=2
XMmem3 net5 V_mem net6 psub sg13_hv_nmos w=1u l=2u ng=1 m=2
XMmem4 net6 V_mem GND psub sg13_hv_nmos w=1u l=2u ng=1 m=2
XMdum1 GND GND GND psub sg13_hv_nmos w=6u l=2u ng=6 m=2
XMdum2 GND GND GND psub sg13_hv_nmos w=1u l=2u ng=1 m=2
XMdum3 out GND GND psub sg13_hv_nmos w=1u l=2u ng=1 m=2
XMdum4 VDD VDD VDD nwell sg13_hv_pmos w=6u l=2u ng=6 m=2
XMdum5 VDD VDD VDD nwell sg13_hv_pmos w=1u l=2u ng=1 m=3
XMdum6 out VDD VDD nwell sg13_hv_pmos w=1u l=2u ng=1 m=2
XMdum7 V_mem VDD VDD nwell sg13_hv_pmos w=1u l=2u ng=1
XR1 VDD nwell ntap1 R=4.4 w=16e-6 l=10.5e-6 rw=0.3e-6
XR2 GND psub ptap1 R=4.829 w=16e-6 l=8.2e-6 rw=0.3e-6
.ends

* expanding   symbol:  REF_system.sym # of pins=6
** sym_path: /foss/designs/adex_neuron/chenxi_working/ttihp26a-adex-neuron-ncs/xschem/REF_system.sym
** sch_path: /foss/designs/adex_neuron/chenxi_working/ttihp26a-adex-neuron-ncs/xschem/REF_system.sch
.subckt REF_system VDD ACK V_mem REQ V_ref GND
*.iopin VDD
*.iopin GND
*.ipin V_ref
*.ipin REQ
*.ipin ACK
*.ipin V_mem
Cr Vref GND 0.5p
XM10 Vref REQ net2 VDD sg13_hv_pmos w=1u l=0.5u ng=1
XM11 Vref REQ net1 GND sg13_hv_nmos w=1u l=0.5u ng=1
XM12 net2 ACK VDD VDD sg13_hv_pmos w=1u l=0.5u ng=1
XM13 V_mem Vref GND GND sg13_hv_nmos w=1u l=0.5u ng=1
XM14 net1 V_ref GND GND sg13_hv_nmos w=4u l=4u ng=2 m=4
.ends

.GLOBAL GND
.GLOBAL VDD
.end
