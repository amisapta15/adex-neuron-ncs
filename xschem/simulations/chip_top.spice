** sch_path: /foss/designs/adex_neuron/ttihp26a-adex-neuron-ncs/xschem/chip_top.sch
.subckt chip_top VDPWR VGND ui_in[7] ui_in[6] ui_in[5] ui_in[4] ui_in[3] ui_in[2] ui_in[1] ui_in[0] uo_out[7] uo_out[6] uo_out[5]
+ uo_out[4] uo_out[3] uo_out[2] uo_out[1] uo_out[0] uio_in[7] uio_in[6] uio_in[5] uio_in[4] uio_in[3] uio_in[2] uio_in[1] uio_in[0]
+ uio_out[7] uio_out[6] uio_out[5] uio_out[4] uio_out[3] uio_out[2] uio_out[1] uio_out[0] uio_oe[7] uio_oe[6] uio_oe[5] uio_oe[4] uio_oe[3]
+ uio_oe[2] uio_oe[1] uio_oe[0] ua[5] ua[4] ua[3] ua[2] ua[1] ua[0]
*.PININFO VDPWR:B VGND:B ui_in[7:0]:I uo_out[7:0]:O uio_in[7:0]:I uio_out[7:0]:O uio_oe[7:0]:O ua[5:0]:B
xrow[10] VDPWR VGND VDPWR VGND ua[4] ua[5] NN_mem_VNT[10] ua[3] ua[2] uio_out[7] ua[1] NN_refcap_VT[10] uio_in[4] neuron_row
xrow[9] VDPWR VGND VDPWR VGND ua[4] ua[5] NN_mem_VNT[9] ua[3] ua[2] uio_out[6] ua[1] NN_refcap_VT[9] uio_in[3] neuron_row
xrow[8] VDPWR VGND VDPWR VGND ua[4] ua[5] NN_mem_VNT[8] ua[3] ua[2] uio_out[5] ua[1] NN_refcap_VT[8] uio_in[2] neuron_row
xrow[7] VDPWR VGND VDPWR VGND ua[4] ua[5] NN_mem_VNT[7] ua[3] ua[2] uo_out[7] ua[1] NN_refcap_VT[7] ui_in[7] neuron_row
xrow[6] VDPWR VGND VDPWR VGND ua[4] ua[5] NN_mem_VNT[6] ua[3] ua[2] uo_out[6] ua[1] NN_refcap_VT[6] ui_in[6] neuron_row
xrow[5] VDPWR VGND VDPWR VGND ua[4] ua[5] NN_mem_VNT[5] ua[3] ua[2] uo_out[5] ua[1] NN_refcap_VT[5] ui_in[5] neuron_row
xrow[4] VDPWR VGND VDPWR VGND ua[4] ua[5] NN_mem_VNT[4] ua[3] ua[2] uo_out[4] ua[1] NN_refcap_VT[4] ui_in[4] neuron_row
xrow[3] VDPWR VGND VDPWR VGND ua[4] ua[5] NN_mem_VNT[3] ua[3] ua[2] uo_out[3] ua[1] NN_refcap_VT[3] ui_in[3] neuron_row
xrow[2] VDPWR VGND VDPWR VGND ua[4] ua[5] NN_mem_VNT[2] ua[3] ua[2] uo_out[2] ua[1] NN_refcap_VT[2] ui_in[2] neuron_row
xrow[1] VDPWR VGND VDPWR VGND ua[4] ua[5] NN_mem_VNT[1] ua[3] ua[2] uo_out[1] ua[1] NN_refcap_VT[1] ui_in[1] neuron_row
xrow[0] VDPWR VGND VDPWR VGND ua[4] ua[5] NN_mem_VNT[0] ua[3] ua[2] uo_out[0] ua[1] NN_refcap_VT[0] ui_in[0] neuron_row
xabuf mux2buf_V VDPWR ua[4] ua[0] VGND buffer_final
xmux VDPWR VGND NN_mem_VNT[5] NN_refcap_VT[5] uio_in[0] uio_in[1] mux2buf_V mux21
xoebuf[7] uio_oe[7] VDPWR VDD VSS sg13g2_buf_1
xoebuf[6] uio_oe[6] VDPWR VDD VSS sg13g2_buf_1
xoebuf[5] uio_oe[5] VDPWR VDD VSS sg13g2_buf_1
xoebuf[4] uio_oe[4] VGND VDD VSS sg13g2_buf_1
xoebuf[3] uio_oe[3] VGND VDD VSS sg13g2_buf_1
xoebuf[2] uio_oe[2] VGND VDD VSS sg13g2_buf_1
xoebuf[1] uio_oe[1] VGND VDD VSS sg13g2_buf_1
xoebuf[0] uio_oe[0] VGND VDD VSS sg13g2_buf_1
.ends

* expanding   symbol:  neuron_row.sym # of pins=13
** sym_path: /foss/designs/adex_neuron/ttihp26a-adex-neuron-ncs/xschem/neuron_row.sym
** sch_path: /foss/designs/adex_neuron/ttihp26a-adex-neuron-ncs/xschem/neuron_row.sch
.subckt neuron_row VDD GND nwell psub bias_VPI in_VI mem_VNTO cm_VI tau_VNI req_VABO ref_VNI refcap_VTO ack_VABI
*.PININFO in_VI:I cm_VI:I bias_VPI:I VDD:B GND:B nwell:B psub:B mem_VNTO:O req_VABO:O refcap_VTO:O tau_VNI:I ref_VNI:I ack_VABI:I
Xneuron VDD I_in tau_VNI mem_VNTO req_VABO ack_VABI ref_VNI GND refcap_VTO psub nwell neuron_noahp
xv2i VDD bias_VPI cm_VI in_VI I_in GND nwell psub V2I_shift_final
.ends

* expanding   symbol:  buffer_final.sym # of pins=5
** sym_path: /foss/designs/adex_neuron/ttihp26a-adex-neuron-ncs/xschem/buffer_final.sym
** sch_path: /foss/designs/adex_neuron/ttihp26a-adex-neuron-ncs/xschem/buffer_final.sch
.subckt buffer_final inp_cm VDD Vbias out GND
*.PININFO inp_cm:I out:O VDD:B GND:B Vbias:I
M2 Vm inp_cm Vb nwell sg13_hv_pmos w=4u l=1u ng=1 m=4
M5 Vm Vm GND psub sg13_hv_nmos w=4u l=1u ng=1 m=4
M13 Vb Vbias VDD nwell sg13_hv_pmos w=4u l=1u ng=1 m=4
M3 out out Vb nwell sg13_hv_pmos w=4u l=1u ng=1 m=4
M1 out Vm GND psub sg13_hv_nmos w=4u l=1u ng=1 m=4
R1 GND psub ptap1 A=6.084e-13 P=3.12e-06
R2 VDD nwell ntap1 A=6.084e-13 P=3.12e-06
MDBIAS VDD VDD VDD nwell sg13_hv_pmos w=4u l=1u ng=2 m=4
MDdiffINP Vb Vb Vb nwell sg13_hv_pmos w=4u l=1u ng=2 m=2
MDdiffINN Vb Vb Vb nwell sg13_hv_pmos w=4u l=1u ng=2 m=2
MDNMIRA GND GND GND psub sg13_hv_nmos w=4u l=1u ng=2 m=2
MDNMIRB GND GND GND psub sg13_hv_nmos w=4u l=1u ng=2 m=2
.ends

* expanding   symbol:  mux21.sym # of pins=7
** sym_path: /foss/designs/adex_neuron/ttihp26a-adex-neuron-ncs/xschem/mux21.sym
** sch_path: /foss/designs/adex_neuron/ttihp26a-adex-neuron-ncs/xschem/mux21.sch
.subckt mux21 VDD VSS IN0 IN1 SEL0 SEL1 OUT
*.PININFO VDD:B VSS:B IN0:I IN1:I SEL0:I SEL1:I OUT:O
x1 VDD VSS SEL0 OUT IN0 tg_lv
x2 VDD VSS SEL1 OUT IN1 tg_lv
.ends

* expanding   symbol:  neuron_noahp.sym # of pins=11
** sym_path: /foss/designs/adex_neuron/ttihp26a-adex-neuron-ncs/xschem/neuron_noahp.sym
** sch_path: /foss/designs/adex_neuron/ttihp26a-adex-neuron-ncs/xschem/neuron_noahp.sch
.subckt neuron_noahp VDD I_in V_lk Vmem REQ ACK V_ref GND Vrefcap psub nwell
*.PININFO V_ref:I GND:B VDD:B REQ:O ACK:I I_in:I V_lk:I Vmem:O Vrefcap:O psub:B nwell:B
Xinv1 VDD Vfb net1 GND inv
Xinv2 VDD net1 REQ GND inv
Xdpi1 I_in VDD Vmem V_lk GND nwell psub DPI
Xfb VDD Vfb Vmem GND nwell psub FB_system
Xref ACK Vmem REQ Vrefcap GND V_ref VDD nwell psub REF_system
Cmem Vmem GND cap_cmim w=44.4e-6 l=15e-6
Cref Vrefcap GND cap_cmim w=22.1e-6 l=15e-6
.ends

* expanding   symbol:  V2I_shift_final.sym # of pins=8
** sym_path: /foss/designs/adex_neuron/ttihp26a-adex-neuron-ncs/xschem/V2I_shift_final.sym
** sch_path: /foss/designs/adex_neuron/ttihp26a-adex-neuron-ncs/xschem/V2I_shift_final.sch
.subckt V2I_shift_final VDD Vbias inn_cm inp_cm out GND nwell psub
*.PININFO inn_cm:I inp_cm:I out:O Vbias:I VDD:B GND:B psub:B nwell:B
MIRA Vm Vm GND psub sg13_hv_nmos w=4u l=1u ng=2 m=4
MBIAS Vb Vbias VDD nwell sg13_hv_pmos w=4u l=1u ng=2 m=4
MIRB out Vm GND psub sg13_hv_nmos w=4u l=1u ng=2 m=4
MdiffINN out inn_cm Vb nwell sg13_hv_pmos w=4u l=1u ng=2 m=4
MDBIAS VDD VDD VDD nwell sg13_hv_pmos w=4u l=1u ng=2 m=2
MIDC out Vbias VDD nwell sg13_hv_pmos w=3u l=1u ng=2 m=4
MDIDC VDD VDD VDD nwell sg13_hv_pmos w=3u l=1u ng=2 m=2
MdiffINP Vm inp_cm Vb nwell sg13_hv_pmos w=4u l=1u ng=2 m=4
MDdiffINP Vb Vb Vb nwell sg13_hv_pmos w=4u l=1u ng=2 m=2
MDdiffINN Vb Vb Vb nwell sg13_hv_pmos w=4u l=1u ng=2 m=2
MDNMIRA GND GND GND psub sg13_hv_nmos w=4u l=1u ng=2 m=2
MDNMIRB GND GND GND psub sg13_hv_nmos w=4u l=1u ng=2 m=2
R3 GND psub ptap1 A=1.452e-11 P=9.68e-05
R1 VDD nwell ntap1 A=1.896e-11 P=0.0001264
.ends

* expanding   symbol:  tg_lv.sym # of pins=5
** sym_path: /foss/designs/adex_neuron/ttihp26a-adex-neuron-ncs/xschem/tg_lv.sym
** sch_path: /foss/designs/adex_neuron/ttihp26a-adex-neuron-ncs/xschem/tg_lv.sch
.subckt tg_lv VDD VSS SEL OUT IN
*.PININFO IN:I VDD:B VSS:B OUT:O SEL:I
x1 VDD SEL selbar VSS inv_lv
M3 IN SEL OUT VSS sg13_lv_nmos w=8u l=0.15u ng=8
M4 IN selbar OUT VDD sg13_lv_pmos w=8u l=0.15u ng=8
Mdumm1 VDD VDD VDD VDD sg13_lv_pmos w=1u l=0.15u ng=1 m=2
Mdumm2 VSS VSS VSS VSS sg13_lv_nmos w=1u l=0.15u ng=1 m=2
.ends

* expanding   symbol:  inv.sym # of pins=4
** sym_path: /foss/designs/adex_neuron/ttihp26a-adex-neuron-ncs/xschem/inv.sym
** sch_path: /foss/designs/adex_neuron/ttihp26a-adex-neuron-ncs/xschem/inv.sch
.subckt inv VDD in out GND
*.PININFO in:I VDD:B GND:B out:O
M1 out in VDD nwell sg13_hv_pmos w=4u l=0.5u ng=1
M2 out in GND psub sg13_hv_nmos w=4u l=0.5u ng=1
R1 GND psub ptap1 A=2.75e-12 P=7.5e-06
R2 VDD nwell ntap1 A=2.75e-12 P=7.5e-06
.ends

* expanding   symbol:  DPI.sym # of pins=7
** sym_path: /foss/designs/adex_neuron/ttihp26a-adex-neuron-ncs/xschem/DPI.sym
** sch_path: /foss/designs/adex_neuron/ttihp26a-adex-neuron-ncs/xschem/DPI.sch
.subckt DPI I_in VDD V_mem V_lk GND nwell psub
*.PININFO V_mem:O V_lk:I I_in:I VDD:B GND:B nwell:B psub:B
Mdifl GND V_lk I_in nwell sg13_hv_pmos w=2u l=2u ng=2 m=8
Mdifr V_mem V_mem I_in nwell sg13_hv_pmos w=2u l=2u ng=2 m=8
Mtau V_mem V_lk GND psub sg13_hv_nmos w=4u l=4u ng=2 m=4
R1 VDD nwell ntap1 A=7.56e-12 P=5.1e-05
R2 VDD nwell ntap1 A=2.7e-12 P=1.86e-05
R3 VDD nwell ntap1 A=2.7e-12 P=1.86e-05
R4 GND psub ptap1 A=2.046e-11 P=0.0001364
Mdum1 VDD VDD VDD nwell sg13_hv_pmos w=5u l=2u ng=10 m=2
Mdum2 I_in VDD VDD nwell sg13_hv_pmos w=1u l=2u ng=1 m=8
Mdum3 GND GND GND psub sg13_hv_nmos w=2u l=4u ng=4 m=2
Mdum4 GND GND GND psub sg13_hv_nmos w=0.5u l=3u ng=1 m=4
Mdum5 GND GND GND psub sg13_hv_nmos w=2u l=3u ng=1 m=4
.ends

* expanding   symbol:  FB_system.sym # of pins=6
** sym_path: /foss/designs/adex_neuron/ttihp26a-adex-neuron-ncs/xschem/FB_system.sym
** sch_path: /foss/designs/adex_neuron/ttihp26a-adex-neuron-ncs/xschem/FB_system.sch
.subckt FB_system VDD out V_mem GND nwell psub
*.PININFO out:O V_mem:B VDD:B GND:B nwell:B psub:B
Mmirr Vmir Vmir VDD nwell sg13_hv_pmos w=4u l=2u ng=4
Mmirl4 V_mem Vmir net1 nwell sg13_hv_pmos w=1u l=2u ng=1
Mthr out V_mem Vmir nwell sg13_hv_pmos w=4u l=2u ng=4
Mmem1 out V_mem net2 psub sg13_hv_nmos w=1u l=2u ng=1 m=2
Mmirl3 net1 Vmir net3 nwell sg13_hv_pmos w=1u l=2u ng=1
Mmirl2 net3 Vmir net4 nwell sg13_hv_pmos w=1u l=2u ng=1
Mmirl1 net4 Vmir VDD nwell sg13_hv_pmos w=1u l=2u ng=1
Mmem2 net2 V_mem net5 psub sg13_hv_nmos w=1u l=2u ng=1 m=2
Mmem3 net5 V_mem net6 psub sg13_hv_nmos w=1u l=2u ng=1 m=2
Mmem4 net6 V_mem GND psub sg13_hv_nmos w=1u l=2u ng=1 m=2
Mdum1 GND GND GND psub sg13_hv_nmos w=6u l=2u ng=6 m=2
Mdum2 GND GND GND psub sg13_hv_nmos w=1u l=2u ng=1 m=2
Mdum3 out GND GND psub sg13_hv_nmos w=1u l=2u ng=1 m=2
Mdum4 VDD VDD VDD nwell sg13_hv_pmos w=6u l=2u ng=6 m=2
Mdum5 VDD VDD VDD nwell sg13_hv_pmos w=1u l=2u ng=1 m=3
Mdum6 out VDD VDD nwell sg13_hv_pmos w=1u l=2u ng=1 m=2
Mdum7 V_mem VDD VDD nwell sg13_hv_pmos w=1u l=2u ng=1
R1 VDD nwell ntap1 A=1.554e-11 P=0.0001036
R2 GND psub ptap1 A=1.416e-11 P=9.44e-05
.ends

* expanding   symbol:  REF_system.sym # of pins=9
** sym_path: /foss/designs/adex_neuron/ttihp26a-adex-neuron-ncs/xschem/REF_system.sym
** sch_path: /foss/designs/adex_neuron/ttihp26a-adex-neuron-ncs/xschem/REF_system.sch
.subckt REF_system ACK V_mem REQ Vrefcap GND V_ref VDD nwell psub
*.PININFO VDD:B GND:B V_ref:I REQ:I ACK:I V_mem:I Vrefcap:O nwell:B psub:B
M10 Vrefcap REQ net2 nwell sg13_hv_pmos w=1u l=0.5u ng=1
M11 Vrefcap REQ net1 psub sg13_hv_nmos w=1u l=0.5u ng=1
M12 net2 ACK VDD nwell sg13_hv_pmos w=1u l=0.5u ng=1
M13 V_mem Vrefcap GND psub sg13_hv_nmos w=1u l=0.5u ng=1
M14 net1 V_ref GND psub sg13_hv_nmos w=4u l=4u ng=2 m=4
.ends

* expanding   symbol:  inv_lv.sym # of pins=4
** sym_path: /foss/designs/adex_neuron/ttihp26a-adex-neuron-ncs/xschem/inv_lv.sym
** sch_path: /foss/designs/adex_neuron/ttihp26a-adex-neuron-ncs/xschem/inv_lv.sch
.subckt inv_lv VDD in out VSS
*.PININFO in:I out:O VDD:B VSS:B
M3 out in VDD VDD sg13_lv_pmos w=1u l=0.15u ng=1
M4 out in VSS VSS sg13_lv_nmos w=1u l=0.15u ng=1
Mdumm1 VDD VDD VDD VDD sg13_lv_pmos w=1u l=0.15u ng=1 m=2
Mdumm2 VSS VSS VSS VSS sg13_lv_nmos w=1u l=0.15u ng=1 m=2
.ends
