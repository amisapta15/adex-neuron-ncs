** sch_path: /foss/designs/adex_neuron/ttihp26a-adex-neuron-ncs/xschem/neuron_noahp.sch
**.subckt neuron_noahp VDD I_in V_th V_lk Vmem REQ ACK V_ref GND
*.ipin V_ref
*.iopin GND
*.iopin VDD
*.opin REQ
*.ipin ACK
*.ipin I_in
*.ipin V_th
*.ipin V_lk
*.opin Vmem
Xinv1 VDD Vfb net1 GND inv
Xinv2 VDD net1 REQ GND inv
Xdpi1 I_in VDD V_th Vmem V_lk GND DPI
Xfb VDD Vfb Vmem GND FB_system
Xref VDD ACK Vmem REQ V_ref GND REF_system
Cmem Vmem GND 1p
**.ends

* expanding   symbol:  inv.sym # of pins=4
** sym_path: /foss/designs/adex_neuron/ttihp26a-adex-neuron-ncs/xschem/inv.sym
** sch_path: /foss/designs/adex_neuron/ttihp26a-adex-neuron-ncs/xschem/inv.sch
.subckt inv VDD in out GND
*.ipin in
*.iopin VDD
*.iopin GND
*.opin out
XM1 out in VDD VDD sg13_hv_pmos w=1u l=0.5u ng=1
XM2 out in GND GND sg13_hv_nmos w=1u l=0.5u ng=1
.ends

* expanding   symbol:  DPI.sym # of pins=6
** sym_path: /foss/designs/adex_neuron/ttihp26a-adex-neuron-ncs/xschem/DPI.sym
** sch_path: /foss/designs/adex_neuron/ttihp26a-adex-neuron-ncs/xschem/DPI.sch
.subckt DPI I_in VDD V_th V_mem V_lk GND
*.opin V_mem
*.ipin V_lk
*.ipin V_th
*.ipin I_in
*.iopin VDD
*.iopin GND
XMdifl GND V_th I_in VDD sg13_hv_pmos w=4u l=8u ng=4 m=4
XMdifr V_mem V_mem I_in VDD sg13_hv_pmos w=4u l=8u ng=4 m=4
XMtau net1 V_lk GND GND sg13_hv_nmos w=4u l=10u ng=2 m=4
Vilk V_mem net1 0
.save i(vilk)
.ends

* expanding   symbol:  FB_system.sym # of pins=4
** sym_path: /foss/designs/adex_neuron/ttihp26a-adex-neuron-ncs/xschem/FB_system.sym
** sch_path: /foss/designs/adex_neuron/ttihp26a-adex-neuron-ncs/xschem/FB_system.sch
.subckt FB_system VDD out V_mem GND
*.opin out
*.iopin V_mem
*.iopin VDD
*.iopin GND
XMmirr Vmir Vmir VDD VDD sg13_hv_pmos w=4u l=2u ng=4
XMfbsw V_mem out net1 VDD sg13_hv_pmos w=1u l=0.5u ng=2
XMmirl4 net1 Vmir net2 VDD sg13_hv_pmos w=1u l=2u ng=1
XMthr out V_mem Vmir VDD sg13_hv_pmos w=1u l=2u ng=2 m=4
XMmem1 out V_mem net3 GND sg13_hv_nmos w=1u l=2u ng=1 m=2
XMmirl3 net2 Vmir net4 VDD sg13_hv_pmos w=1u l=2u ng=1
XMmirl2 net4 Vmir net5 VDD sg13_hv_pmos w=1u l=2u ng=1
XMmirl1 net5 Vmir VDD VDD sg13_hv_pmos w=1u l=2u ng=1
XMmem2 net3 V_mem net6 GND sg13_hv_nmos w=1u l=2u ng=1 m=2
XMmem3 net6 V_mem net7 GND sg13_hv_nmos w=1u l=2u ng=1 m=2
XMmem4 net7 V_mem GND GND sg13_hv_nmos w=1u l=2u ng=1 m=2
.ends

* expanding   symbol:  REF_system.sym # of pins=6
** sym_path: /foss/designs/adex_neuron/ttihp26a-adex-neuron-ncs/xschem/REF_system.sym
** sch_path: /foss/designs/adex_neuron/ttihp26a-adex-neuron-ncs/xschem/REF_system.sch
.subckt REF_system VDD ACK V_mem REQ V_ref GND
*.iopin VDD
*.iopin GND
*.ipin V_ref
*.ipin REQ
*.ipin ACK
*.ipin V_mem
Cr Vref GND 0.5p
XM10 Vref REQ net2 VDD sg13_hv_pmos w=1u l=0.5u ng=1
XM11 Vref REQ net1 GND sg13_hv_nmos w=1u l=0.5u ng=1
XM12 net2 ACK VDD VDD sg13_hv_pmos w=1u l=0.5u ng=1
XM13 V_mem Vref GND GND sg13_hv_nmos w=1u l=0.5u ng=1
XM14 net1 V_ref GND GND sg13_hv_nmos w=4u l=4u ng=2 m=4
.ends

.end
