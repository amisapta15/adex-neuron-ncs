** sch_path: /foss/designs/adex_neuron/ttihp26a-adex-neuron-ncs/xschem/FB_system.sch
.subckt FB_system VDD out V_mem GND
*.PININFO out:O V_mem:B VDD:B GND:B
Mmirr Vmir Vmir VDD VDD sg13_hv_pmos w=4u l=2u ng=4
Mmirl4 V_mem Vmir net1 VDD sg13_hv_pmos w=1u l=2u ng=1
Mthr out V_mem Vmir VDD sg13_hv_pmos w=4u l=2u ng=4
Mmem1 out V_mem net2 GND sg13_hv_nmos w=1u l=2u ng=1 m=2
Mmirl3 net1 Vmir net3 VDD sg13_hv_pmos w=1u l=2u ng=1
Mmirl2 net3 Vmir net4 VDD sg13_hv_pmos w=1u l=2u ng=1
Mmirl1 net4 Vmir VDD VDD sg13_hv_pmos w=1u l=2u ng=1
Mmem2 net2 V_mem net5 GND sg13_hv_nmos w=1u l=2u ng=1 m=2
Mmem3 net5 V_mem net6 GND sg13_hv_nmos w=1u l=2u ng=1 m=2
Mmem4 net6 V_mem GND GND sg13_hv_nmos w=1u l=2u ng=1 m=2
Mdum1 GND GND GND GND sg13_hv_nmos w=6u l=2u ng=6 m=2
Mdum2 GND GND GND GND sg13_hv_nmos w=1u l=2u ng=1 m=2
Mdum3 out GND GND GND sg13_hv_nmos w=1u l=2u ng=1 m=2
Mdum4 VDD VDD VDD VDD sg13_hv_pmos w=6u l=2u ng=6 m=2
Mdum5 VDD VDD VDD VDD sg13_hv_pmos w=1u l=2u ng=1 m=3
Mdum6 out VDD VDD VDD sg13_hv_pmos w=1u l=2u ng=1 m=2
Mdum7 V_mem VDD VDD VDD sg13_hv_pmos w=1u l=2u ng=1
.ends
