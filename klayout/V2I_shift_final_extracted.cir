* Extracted by KLayout with SG13G2 LVS runset on : 18/03/2026 01:11

.SUBCKT V2I_shift_final GND out Vm VDD Vb inn_cm inp_cm Vbias
M$1 GND GND GND \$1 sg13_hv_nmos L=1u W=16u AS=3.64p AD=3.64p PS=23.64u
+ PD=23.64u
M$3 GND Vm out \$1 sg13_hv_nmos L=1u W=16u AS=3.04p AD=3.04p PS=19.04u PD=19.04u
M$5 GND Vm Vm \$1 sg13_hv_nmos L=1u W=16u AS=3.04p AD=3.04p PS=19.04u PD=19.04u
M$25 Vb Vb Vb \$18 sg13_hv_pmos L=1u W=16u AS=3.64p AD=3.64p PS=23.64u PD=23.64u
M$27 Vb inn_cm out \$18 sg13_hv_pmos L=1u W=16u AS=3.04p AD=3.04p PS=19.04u
+ PD=19.04u
M$29 Vb inp_cm Vm \$18 sg13_hv_pmos L=1u W=16u AS=3.04p AD=3.04p PS=19.04u
+ PD=19.04u
M$49 VDD VDD VDD \$18 sg13_hv_pmos L=1u W=14u AS=3.185p AD=3.185p PS=21.14u
+ PD=21.14u
M$51 VDD Vbias out \$18 sg13_hv_pmos L=1u W=12u AS=2.505p AD=2.505p PS=16.84u
+ PD=16.84u
M$55 VDD Vbias Vb \$18 sg13_hv_pmos L=1u W=16u AS=3.34p AD=3.34p PS=21.34u
+ PD=21.34u
R$73 \$18 VDD ntap1 A=18.96p P=126.4u
R$74 \$1 GND ptap1 A=14.52p P=96.8u
.ENDS V2I_shift_final
