** sch_path: /foss/designs/ttihp26a-adex-neuron-ncs/xschem/neuron.sch
.subckt neuron VDD I_in V_th V_lk Vmem REQ V_adapt V_thrahp CapAdap ACK V_lkahp V_ref GND
*.ipin V_ref
*.iopin GND
*.iopin VDD
*.opin REQ
*.ipin ACK
*.ipin I_in
*.ipin V_th
*.ipin V_lk
*.ipin V_adapt
*.ipin V_thrahp
*.ipin V_lkahp
*.opin CapAdap
*.opin Vmem
Xinv1 VDD net2 net1 GND inv
Xinv2 VDD net1 REQ GND inv
Xdpi1 I_in VDD V_th Vmem V_lk GND DPI
Xfb VDD net2 Vmem GND FB_system
Xadap VDD REQ CapAdap V_adapt I_in V_thrahp V_lkahp GND ADAP_system
Xref VDD ACK Vmem REQ V_ref GND REF_system
Cmem Vmem GND 1e-12
.ends neuron

* expanding   symbol:  inv.sym # of pins=4
** sym_path: /foss/designs/ttihp26a-adex-neuron-ncs/xschem/inv.sym
** sch_path: /foss/designs/ttihp26a-adex-neuron-ncs/xschem/inv.sch
.subckt inv VDD in out GND
*.ipin in
*.iopin VDD
*.iopin GND
*.opin out
M1 out in VDD VDD sg13_hv_pmos w=1e-06 l=5e-07 ng=1
M2 out in GND GND sg13_hv_nmos w=1e-06 l=5e-07 ng=1
.ends

* expanding   symbol:  DPI.sym # of pins=6
** sym_path: /foss/designs/ttihp26a-adex-neuron-ncs/xschem/DPI.sym
** sch_path: /foss/designs/ttihp26a-adex-neuron-ncs/xschem/DPI.sch
.subckt DPI I_in VDD V_th V_mem V_lk GND
*.opin V_mem
*.ipin V_lk
*.ipin V_th
*.ipin I_in
*.iopin VDD
*.iopin GND
Mdifl GND V_th I_in VDD sg13_hv_pmos w=4e-06 l=8e-06 ng=4 m=4
Mdifr V_mem V_mem I_in VDD sg13_hv_pmos w=4e-06 l=8e-06 ng=4 m=4
Mtau V_mem V_lk GND GND sg13_hv_nmos w=4e-06 l=1e-05 ng=2 m=4
.ends

* expanding   symbol:  FB_system.sym # of pins=4
** sym_path: /foss/designs/ttihp26a-adex-neuron-ncs/xschem/FB_system.sym
** sch_path: /foss/designs/ttihp26a-adex-neuron-ncs/xschem/FB_system.sch
.subckt FB_system VDD out V_mem GND
*.opin out
*.iopin V_mem
*.iopin VDD
*.iopin GND
M3 Vmir Vmir VDD VDD sg13_hv_pmos w=1e-06 l=2e-06 ng=2 m=4
M20 V_mem out net1 VDD sg13_hv_pmos w=1e-06 l=5e-07 ng=2
M2 net1 Vmir VDD VDD sg13_hv_pmos w=1e-06 l=8e-06 ng=2
M23 out V_mem Vmir VDD sg13_hv_pmos w=1e-06 l=2e-06 ng=2 m=4
M4 out V_mem GND GND sg13_hv_nmos w=1e-06 l=8e-06 ng=2 m=2
.ends

* expanding   symbol:  ADAP_system.sym # of pins=8
** sym_path: /foss/designs/ttihp26a-adex-neuron-ncs/xschem/ADAP_system.sym
** sch_path: /foss/designs/ttihp26a-adex-neuron-ncs/xschem/ADAP_system.sch
.subckt ADAP_system VDD REQ CapAdap V_adapt I_in V_thrahp V_lkahp GND
*.iopin VDD
*.iopin GND
*.ipin REQ
*.ipin V_adapt
*.ipin V_thrahp
*.ipin V_lkahp
*.ipin I_in
*.opin CapAdap
M19 net2 REQ VDD VDD sg13_hv_pmos w=1e-06 l=5e-07 ng=1
M21 net1 V_adapt net2 VDD sg13_hv_pmos w=4e-06 l=4e-06 ng=2 m=4
M18 I_in CapAdap GND GND sg13_hv_nmos w=4e-06 l=4e-06 ng=2 m=4
Cmem2 CapAdap GND 2e-12
Xdpi2 net1 VDD V_thrahp CapAdap V_lkahp GND DPI
.ends

* expanding   symbol:  REF_system.sym # of pins=6
** sym_path: /foss/designs/ttihp26a-adex-neuron-ncs/xschem/REF_system.sym
** sch_path: /foss/designs/ttihp26a-adex-neuron-ncs/xschem/REF_system.sch
.subckt REF_system VDD ACK V_mem REQ V_ref GND
*.iopin VDD
*.iopin GND
*.ipin V_ref
*.ipin REQ
*.ipin ACK
*.ipin V_mem
Cr Vref GND 5e-13
M10 Vref REQ net2 VDD sg13_hv_pmos w=1e-06 l=5e-07 ng=1
M11 Vref REQ net1 GND sg13_hv_nmos w=1e-06 l=5e-07 ng=1
M12 net2 ACK VDD VDD sg13_hv_pmos w=1e-06 l=5e-07 ng=1
M13 V_mem Vref GND GND sg13_hv_nmos w=1e-06 l=5e-07 ng=1
M14 net1 V_ref GND GND sg13_hv_nmos w=4e-06 l=4e-06 ng=2 m=4
.ends

.end
