** sch_path: /foss/designs/ttihp26a-adex-neuron-ncs/xschem/inv.sch
.subckt inv VDD in out GND
*.ipin in
*.iopin VDD
*.iopin GND
*.opin out
M1 out in VDD VDD sg13_hv_pmos w=1e-06 l=5e-07 ng=1
M2 out in GND GND sg13_hv_nmos w=1e-06 l=5e-07 ng=1
.ends inv
.end
