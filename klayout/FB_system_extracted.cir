* Extracted by KLayout with SG13G2 LVS runset on : 12/03/2026 17:56

.SUBCKT FB_system 2 6 7 9
M$1 2 2 2 1 sg13_hv_nmos L=2u W=14u AS=3.26p AD=2.96p PS=24.52u PD=21.92u
M$8 2 7 3 1 sg13_hv_nmos L=2u W=2u AS=0.38p AD=0.38p PS=2.76u PD=2.76u
M$9 3 7 4 1 sg13_hv_nmos L=2u W=2u AS=0.38p AD=0.38p PS=2.76u PD=2.76u
M$10 4 7 5 1 sg13_hv_nmos L=2u W=2u AS=0.38p AD=0.38p PS=2.76u PD=2.76u
M$11 5 7 6 1 sg13_hv_nmos L=2u W=2u AS=0.38p AD=0.38p PS=2.76u PD=2.76u
M$12 6 2 2 1 sg13_hv_nmos L=2u W=2u AS=0.38p AD=0.68p PS=2.76u PD=5.36u
M$25 9 9 9 8 sg13_hv_pmos L=2u W=15u AS=3.3p AD=3.45p PS=24.6u PD=25.9u
M$31 9 9 6 8 sg13_hv_pmos L=2u W=2u AS=0.53p AD=0.53p PS=4.06u PD=4.06u
M$32 6 7 10 8 sg13_hv_pmos L=2u W=4u AS=0.76p AD=0.76p PS=5.52u PD=5.52u
M$38 9 10 10 8 sg13_hv_pmos L=2u W=4u AS=0.76p AD=0.76p PS=5.52u PD=5.52u
M$43 9 9 7 8 sg13_hv_pmos L=2u W=1u AS=0.34p AD=0.19p PS=2.68u PD=1.38u
M$44 7 10 11 8 sg13_hv_pmos L=2u W=1u AS=0.19p AD=0.19p PS=1.38u PD=1.38u
M$45 11 10 12 8 sg13_hv_pmos L=2u W=1u AS=0.19p AD=0.19p PS=1.38u PD=1.38u
M$46 12 10 13 8 sg13_hv_pmos L=2u W=1u AS=0.19p AD=0.19p PS=1.38u PD=1.38u
M$47 13 10 9 8 sg13_hv_pmos L=2u W=1u AS=0.19p AD=0.19p PS=1.38u PD=1.38u
R$55 8 9 ntap1 A=15.54p P=103.6u
R$56 1 2 ptap1 A=14.16p P=94.4u
.ENDS FB_system
