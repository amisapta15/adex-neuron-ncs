** sch_path: /foss/designs/adex_neuron/chenxi_working/ttihp26a-adex-neuron-ncs/xschem/V2I_shift_final.sch
.subckt V2I_shift_final VDD Vbias inn_cm inp_cm out GND nwell psub
*.PININFO inn_cm:I inp_cm:I out:O Vbias:I VDD:B GND:B psub:B nwell:B
MIRA Vm Vm GND psub sg13_hv_nmos w=4u l=1u ng=2 m=4
MBIAS Vb Vbias VDD nwell sg13_hv_pmos w=4u l=1u ng=2 m=4
MIRB out Vm GND psub sg13_hv_nmos w=4u l=1u ng=2 m=4
MdiffINN out inn_cm Vb nwell sg13_hv_pmos w=4u l=1u ng=2 m=4
MDBIAS VDD VDD VDD nwell sg13_hv_pmos w=4u l=1u ng=2 m=2
MIDC out Vbias VDD nwell sg13_hv_pmos w=3u l=1u ng=2 m=4
MDIDC VDD VDD VDD nwell sg13_hv_pmos w=3u l=1u ng=2 m=2
MdiffINP Vm inp_cm Vb nwell sg13_hv_pmos w=4u l=1u ng=2 m=4
MDdiffINP Vb Vb Vb nwell sg13_hv_pmos w=4u l=1u ng=2 m=2
MDdiffINN Vb Vb Vb nwell sg13_hv_pmos w=4u l=1u ng=2 m=2
MDNMIRA GND GND GND psub sg13_hv_nmos w=4u l=1u ng=2 m=2
MDNMIRB GND GND GND psub sg13_hv_nmos w=4u l=1u ng=2 m=2
R3 GND psub ptap1 A=1.452e-11 P=9.68e-05
R1 VDD nwell ntap1 A=1.896e-11 P=0.0001264
.ends
