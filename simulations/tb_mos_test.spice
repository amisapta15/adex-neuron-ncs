** sch_path: /foss/designs/adex_neuron/ttihp26a-adex-neuron-ncs/xschem/tb_mos_test
**.subckt tb_mos_test
XMn net1 Vg 0 0 sg13_hv_nmos w=1u l=1u ng=1
Vdn VDD net1 0
.save i(vdn)
Vgs Vg 0 0
Vdd VDD 0 1.2
Vdp net2 0 0
.save i(vdp)
XMp net2 Vg VDD VDD sg13_hv_pmos w=1u l=1u ng=1
**** begin user architecture code

.lib cornerMOSlv.lib mos_tt
.lib cornerMOShv.lib mos_tt
.lib cornerHBT.lib hbt_typ
.lib cornerRES.lib res_typ
.lib cornerCAP.lib cap_typ

.param temp=27
.control
save all
dc Vgs 0 1.2 0.01
write dc_hv_sweep.raw
.endc

**** end user architecture code
**.ends
.GLOBAL VDD
.end
